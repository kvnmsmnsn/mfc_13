** sch_path: /home/ttuser/Mfcs/mfc_13/xschem/mfc_13.sch
.subckt mfc_13 gate sbd
*.PININFO gate:I sbd:O
XM2 sbd gate sbd sbd sky130_fd_pr__nfet_01v8 L=0.3 W=3.36 nf=1 m=1
.ends
.end
